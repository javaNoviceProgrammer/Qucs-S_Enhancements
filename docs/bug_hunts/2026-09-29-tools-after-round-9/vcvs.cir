* vcvs across V
V1 1 0 DC 5
E1 1 0 2 2 1
R2 2 0 1k
.op
.print dc v(1)
.end
